* SDR direct-conversion receiver - generated by export_ngspice.py
* Source of truth: sim/scripts/sdr_skidl_circuit.py (60 parts)
*
* Active devices are behavioural macromodels: the common-gate LNAs and the
* zero-IF mixer have no standard SPICE primitive, and the baseband buffers are
* limiting voltage followers. The MCU is not simulated here -- it is the
* co-simulation partner (src/picsimlab_fmu).
*
* Node ADC_I / ADC_Q are the STM32 ADC inputs (PA0 / PA1).
.title SDR_Direct_Conversion_Receiver

* ---- 5 V supply -----------------------------------------------------------
V_VIN VIN_5V 0 DC 5.0

* ---- local oscillator -----------------------------------------------------
* The STM32 drives LO from its timer on PA6. Standalone (no co-simulation)
* this is an idealised unit sinusoid at 7.15 MHz; under co-simulation the PicSimLab
* bridge replaces LO_SRC with the real MCU pin state, so the mixer sees
* an actual square/timer waveform rather than a clean tone.
V_LO_SRC LO_SRC 0 DC 0
V_LO LO 0 SIN(0 1.0 7.15Meg 0 0)

* ---- RF input -------------------------------------------------------------
* S11-based antenna networks from export_antenna_ngspice.py can be substituted
* here; this is a matched source standing in for a flat test signal.
V_ANT RF_IN 0 SIN(0 1m 7.15Meg 0 0)
R_TERM_SRC RF_IN GND 50
CC_AF_I ADC_I_F GND 100p
CC_AF_Q ADC_Q_F GND 100p
CC_ANA1 VCC_3V3_ANA GND 10u
CC_ANA2 VCC_3V3_ANA GND 100n
CC_BS1 LNA2_D FIL_IN 100p
CC_BS2 FIL_OUT GND 10p
CC_IN RF_IN LNA1_G 100p
CC_LDO1 VCC_3V3 GND 100u
CC_LDO2 VCC_3V3 GND 100n
CC_LNA1 LNA1_S GND 100p
CC_LO LO GND 100p
CC_MCU1 VCC_3V3 GND 100n
CC_MCU2 VCC_3V3 GND 100n
CC_MCU3 VCC_3V3 GND 4.7u
CC_MIX1 FIL_OUT MIX_IN_P 100p
CC_MIX2 GND MIX_IN_N 100p
CC_MIX3 VCC_MIX GND 100n
CC_OPI ADC_I GND 100p
CC_OPQ ADC_Q GND 100p
CC_OSC1 OSC_IN GND 22p
CC_OSC2 OSC_OUT GND 22p
CC_QWC LNA1_D QWC_IN 100p
RFB1 VCC_3V3 VCC_3V3_ANA 600
LL_BS1 FIL_IN FIL_OUT 100u
LL_LNA1 VCC_3V3 LNA1_D 18u
LL_LNA2 VCC_3V3_ANA LNA2_D 18u
LL_MIX VCC_3V3_ANA VCC_MIX 600
RR_AF_I ADC_I ADC_I_F 10k
RR_AF_Q ADC_Q ADC_Q_F 10k
RR_BS FIL_OUT GND 1k
RR_G1 VCC_3V3 LNA1_G 10k
RR_G2 LNA1_G GND 10k
RR_G3 VCC_3V3 LNA2_G 4.7k
RR_G4 LNA2_G GND 2.2k
RR_LO LO_SRC LO 50
RR_OPI MIX_I1 MIX_I2 10k
RR_OPQ MIX_Q1 MIX_Q2 10k
RR_QWC QWC_CP GND 1k
RR_S1 LNA1_S GND 1k
RR_S2 LNA2_S GND 1k
RR_TERM RF_IN GND 50
RR_USB1 USB_DP USB_DP_R 22
RR_USB2 USB_DN USB_DN_R 22
R_U_OP1_R1 MIX_I1 BB_U_OP1_D1 10k
R_U_OP1_R2 MIX_I2 BB_U_OP1_D1 10k
R_U_OP1_R3 MIX_Q1 BB_U_OP1_D2 10k
R_U_OP1_R4 MIX_Q2 BB_U_OP1_D2 10k
R_Y1_B1 OSC_IN VCC_3V3_ANA 1Meg
R_Y1_B2 OSC_OUT VCC_3V3_ANA 1Meg
E_Q_LNA1 LNA1_D 0 LNA1_G 0 12  $ common-gate LNA stage
E_Q_LNA2 LNA2_D 0 LNA2_G 0 12  $ common-gate LNA stage
B_U_LDO VCC_3V3 0 V = 3.3*ternary_fcn(V(VIN_5V)>3.5, 1, 0)  $ 3V3 LDO
R_U_MIX1_BIASP MIX_IN_P 0 1Meg
R_U_MIX1_BIASN MIX_IN_N 0 1Meg
R_U_MIX1_DIFF MIX_IN_P MIX_U_MIX1_D 1
R_U_MIX1_DIFN MIX_IN_N MIX_U_MIX1_D 1
B_U_MIX1_I MIX_I1 0 V = 0.5 * V(MIX_U_MIX1_D) * V(LO)
B_U_MIX1_Q MIX_Q1 0 V = 0.5 * V(MIX_U_MIX1_D) * V(LO) * 0
R_U_MIX1_TMIX_I2 MIX_I2 MIX_I1 1
R_U_MIX1_TMIX_Q2 MIX_Q2 MIX_Q1 1
B_U_OP1_I ADC_I 0 V = limit(1.0*V(BB_U_OP1_D1), 1.65)  $ I-channel baseband buffer
B_U_OP1_Q ADC_Q 0 V = limit(1.0*V(BB_U_OP1_D2), 1.65)  $ Q-channel baseband buffer
RBLO LO GND 1Gig  $ DC bias: LO has no DC path
RBLO_SRC LO_SRC GND 1Gig  $ DC bias: LO_SRC has no DC path
RBQWC_IN QWC_IN GND 1Gig  $ DC bias: QWC_IN has no DC path
RBUSB_DN USB_DN GND 1Gig  $ DC bias: USB_DN has no DC path
RBUSB_DN_R USB_DN_R GND 1Gig  $ DC bias: USB_DN_R has no DC path
RBUSB_DP USB_DP GND 1Gig  $ DC bias: USB_DP has no DC path
RBUSB_DP_R USB_DP_R GND 1Gig  $ DC bias: USB_DP_R has no DC path
* ---- transient analysis ---------------------------------------------------
.tran 1u 20u

.control
run
print v(ADC_I) v(ADC_Q)
.endc

.end
