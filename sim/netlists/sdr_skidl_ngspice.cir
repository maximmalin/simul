* SDR direct-conversion receiver - generated by export_ngspice.py
* Source of truth: sim/scripts/sdr_skidl_circuit.py (60 parts)
*
* Active devices are behavioural macromodels: the common-gate LNAs and the
* zero-IF mixer have no standard SPICE primitive, and the baseband buffers are
* limiting voltage followers. The MCU is not simulated here -- it is the
* co-simulation partner (src/picsimlab_fmu).
*
* Node ADC_I / ADC_Q are the STM32 ADC inputs (PA0 / PA1).
.title SDR_Direct_Conversion_Receiver

* ---- 5 V supply -----------------------------------------------------------
V_VIN VIN_5V 0 DC 5.0

* ---- digital pin <-> analog node boundary ---------------------------------
* This is the co-simulation boundary. The STM32 is NOT simulated here; PicSimLab
* runs the firmware and drives the *digital* nodes.
*
* The analog -> digital direction uses ngspice's native adc_bridge, which does
* the thresholding properly:
*
*   ADC_I / ADC_Q  analog  ->  adc_bridge  ->  ADC_I_D / ADC_Q_D digital
*
* The digital -> analog direction does NOT use dac_bridge, because its input is
* an event-driven digital node and an external host cannot drive it: `alter
* LO_SRC = 3.3` fails with "no such device or model name". A master simulator
* therefore has to drive the analog side, and the pin is modelled explicitly
* instead -- output resistance, load capacitance, and a finite edge:
*
*   V_MCU_*   host-alterable ideal source (the GPIO idealisation)
*   R_PIN_*   pin output impedance
*   C_PIN_*   pin load capacitance
*   LO / GAIN analog node presented to the circuit
*
* That is still impedance matched: the pin is not an ideal zero-ohm source onto
* the analog network, and the edges are finite, so the solver sees a real load.
* Port vectors on the bridges need square brackets despite the ngspice manual
* showing them unbracketed (ngspice bug #146).
* The thresholds are the STM32F103's own CMOS input levels from Table 29:
* VIL <= 0.35*VDD and VIH >= 0.65*VDD. Between in_low and in_high an adc_bridge
* is a resistance rather than a switch, so these are the digital levels the pin
* would resolve; the analog node ADC_I / ADC_Q is what the ADC actually samples
* and carries the full amplitude.
*
* Note PA0 and PA1 are analog inputs, so strictly no digital threshold applies
* to them -- ngspice cannot hand an analog level into an event-driven domain, so
* this is a 1-bit view of the sampled value, not a claim about the ADC.
.model m_adc adc_bridge(in_low=1.155 in_high=2.145)

A_ADC_I [ADC_I] [ADC_I_D] m_adc
A_ADC_Q [ADC_Q] [ADC_Q_D] m_adc

* --- MCU output pins, driven by the co-simulation host ---
* `alter V_MCU_LO 3.3` is how sdr_picsimlab_cosim.py pushes a PA6 pin state.
V_MCU_GAIN MCU_GAIN 0 DC 0

* --- PA6: the LO timer output ---------------------------------------------
* PA6 does not carry a logic level in this circuit, it carries a *waveform*.
* It is the TIM3_CH1 output that clocks the mixer.
*
* The square wave is a native PULSE source with finite edges rather than a
* behavioural comparator. A hard ternary_fcn threshold is an ideal voltage step
* with no impedance behind it, and into the pin's pF of capacitance ngspice
* collapses the timestep on the first transition and aborts the run -- which is
* what "timestep too small; trouble with node lo_drv" was. A real CMOS timer
* output has a finite edge and a real drive impedance, both of which PULSE plus
* R_LO_OUT reproduce.
*
* The period is the timer's: f = 1/per. The host retunes by
* `alter V_LO_TONE PULSE(0 3.3 0 2n 2n <tp> <per>)`, which is what writing the
* ARR preload register does on the MCU side.
V_LO_TONE LO_TONE 0 PULSE(0 3.3 0 2n 2n 69.4444n 138.889n)

* V_MCU_LO is the host-alterable pin state, the API the co-simulation driver
* already uses. It ships enabled (3.3 V) so a standalone run shows the whole
* chain working; `alter V_MCU_LO 0` stops the timer and the LO with it.
* Multiplying by it either passes the waveform through unchanged or scales it to
* exactly zero, so gating adds no new discontinuity for the solver -- unlike a
* comparator would.
B_LO_GATE LO_DRV 0 V = V(LO_TONE) * V(MCU_EN) / 3.3
V_MCU_LO  MCU_EN 0 DC 3.3

* Comparator/timer output drive impedance.
R_LO_OUT LO_DRV MCU_LO 65.0

* --- LO quadrature splitter (the LT5560's internal 90 deg phase shifter) ----
* H = 1 - 2/(1+sRC) = (sRC-1)/(sRC+1): unity magnitude everywhere and exactly
* +90 deg at omega = 1/RC, so R*C = 1/(2*pi*f_LO) puts the quadrature point on
* the LO fundamental. This is the standard single-op-amp all-pass. Without it
* the Q channel has no phase shift to work with and is identically zero.
* LO_QA_LP is the RC lowpass node; the E source subtracts twice it from the
* direct path, so the driven output node is separate from the RC node.
R_LO_QA  LO LO_QA_LP 10000
C_LO_QA  LO_QA_LP 0 2.21049e-12
E_LO_QA  MIX_U_MIX1_LOQ 0 POLY(2) LO 0 LO_QA_LP 0 0 1 -2

* PA6/PA7 on an F103 in push-pull. The output impedance and the pin capacitance
* are the datasheet's own figures -- see MCU_PIN_ROUT and MCU_PIN_CIO in
* export_ngspice.py for the derivation from Table 30 and Table 29. A real edge
* is finite, which is what stops the transient solver from taking an unbounded
* step across every GPIO transition.
*
* These land on LO_SRC, which is the SKiDL net that carries PA6, not on the
* mixer's LO port. The mixer's own 50 ohm input impedance is RR_LO further along
* the chain.
R_PIN_LO   MCU_LO   LO_SRC 65.0
C_PIN_LO   LO_SRC   0      5.0p
R_PIN_GAIN MCU_GAIN GAIN   65.0
C_PIN_GAIN GAIN    0      5.0p

* ADC inputs are high-impedance; the bridge presents the analog level as
* digital, so all the firmware sees is the thresholded state.
R_D_ADC_I_D ADC_I_D 0 1Gig
R_D_ADC_Q_D ADC_Q_D 0 1Gig

* ---- RF input -------------------------------------------------------------
* S11-based antenna networks from export_antenna_ngspice.py can be substituted
* here; this is a matched source standing in for a flat test signal. The tone is
* offset from the LO by LO_IF_OFFSET, so direct conversion lands the signal in
* the baseband where the ADC can sample it instead of at DC. The amplitude is a
* test level: see RF_LEVEL in export_ngspice.py.
V_ANT RF_IN 0 SIN(0 0.1 7.15e+06 0 0)
R_TERM_SRC RF_IN GND 50

* Printed so a standalone run shows the boundary working: the digital side is
* readable, and so is the analog node the dac_bridge drives.
CC_AF_I ADC_I_F GND 100p
CC_AF_Q ADC_Q_F GND 100p
CC_ANA1 VCC_3V3_ANA GND 10u
CC_ANA2 VCC_3V3_ANA GND 100n
CC_BS1 LNA2_D FIL_IN 100p
CC_BS2 FIL_OUT GND 10p
CC_IN RF_IN LNA1_G 100p
CC_LDO1 VCC_3V3 GND 100u
CC_LDO2 VCC_3V3 GND 100n
CC_LNA1 LNA1_S GND 100p
CC_LO LO GND 100p
CC_MCU1 VCC_3V3 GND 100n
CC_MCU2 VCC_3V3 GND 100n
CC_MCU3 VCC_3V3 GND 4.7u
CC_MIX1 FIL_OUT MIX_IN_P 100p
CC_MIX2 GND MIX_IN_N 100p
CC_MIX3 VCC_MIX GND 100n
CC_OPI ADC_I GND 100p
CC_OPQ ADC_Q GND 100p
CC_OSC1 OSC_IN GND 22p
CC_OSC2 OSC_OUT GND 22p
CC_QWC LNA1_D QWC_IN 100p
RFB1 VCC_3V3 VCC_3V3_ANA 0.5  $ 600R@100MHz ferrite bead, DC resistance
LL_BS1 FIL_IN L_BS1_MID 0.0001
RL_BS1 L_BS1_MID FIL_OUT 8  $ 100u RF choke winding resistance
LL_LNA1 VCC_3V3 L_LNA1_MID 1.8e-05
RL_LNA1 L_LNA1_MID LNA1_D 4  $ 18u RF choke winding resistance
LL_LNA2 VCC_3V3_ANA L_LNA2_MID 1.8e-05
RL_LNA2 L_LNA2_MID LNA2_D 4  $ 18u RF choke winding resistance
RL_MIX VCC_3V3_ANA VCC_MIX 0.5  $ 600R@100MHz ferrite bead, DC resistance
R_Q_LNA1_DRAIN LNA1_D VCC_3V3 2200  $ drain bias load
R_Q_LNA2_DRAIN LNA2_D VCC_3V3 2200  $ drain bias load
RR_AF_I ADC_I ADC_I_F 10k
RR_AF_Q ADC_Q ADC_Q_F 10k
RR_BS FIL_OUT GND 1k
RR_G1 VCC_3V3 LNA1_G 10k
RR_G2 LNA1_G GND 10k
RR_G3 VCC_3V3 LNA2_G 4.7k
RR_G4 LNA2_G GND 2.2k
RR_LO LO_SRC LO 50
RR_OPI MIX_I1 MIX_I2 10k
RR_OPQ MIX_Q1 MIX_Q2 10k
RR_QWC QWC_CP GND 1k
RR_S1 LNA1_S GND 1k
RR_S2 LNA2_S GND 1k
RR_TERM RF_IN GND 50
RR_USB1 USB_DP USB_DP_R 22
RR_USB2 USB_DN USB_DN_R 22
R_U_OP1_R1 MIX_I1 BB_U_OP1_D1 10k
R_U_OP1_R2 MIX_I2 BB_U_OP1_D1 10k
R_U_OP1_R3 MIX_Q1 BB_U_OP1_D2 10k
R_U_OP1_R4 MIX_Q2 BB_U_OP1_D2 10k
R_X_QWC1_CP QWC_CP 0 1k  $ coupler centre port
R_Y1_B1 OSC_IN VCC_3V3_ANA 1Meg
R_Y1_B2 OSC_OUT VCC_3V3_ANA 1Meg
G_Q_LNA1 LNA1_D 0 VALUE = {0.005} + {0.015} * (V(LNA1_G) - 1.65)  $ common-gate LNA, gm into the choke-fed drain
G_Q_LNA2 LNA2_D 0 VALUE = {0.005} + {0.015} * (V(LNA2_G) - 1.052)  $ common-gate LNA, gm into the choke-fed drain
B_U_LDO VCC_3V3 0 V = 3.3*ternary_fcn(V(VIN_5V)>3.5, 1, 0)  $ 3V3 LDO
R_U_MIX1_BIASP MIX_IN_P 0 1Meg
R_U_MIX1_BIASN MIX_IN_N 0 1Meg
R_U_MIX1_DIFF MIX_IN_P MIX_U_MIX1_D 1
R_U_MIX1_DIFN MIX_IN_N MIX_U_MIX1_D 1
B_U_MIX1_I MIX_I1 0 V = 0.5 * V(MIX_U_MIX1_D) * V(LO)
B_U_MIX1_Q MIX_Q1 0 V = 0.5 * V(MIX_U_MIX1_D) * V(MIX_U_MIX1_LOQ)
R_U_MIX1_TMIX_I2 MIX_I2 MIX_I1 1
R_U_MIX1_TMIX_Q2 MIX_Q2 MIX_Q1 1
B_U_OP1_I ADC_I 0 V = 1.65 + 1.65 * tanh(1.0 * V(BB_U_OP1_D1) / 1.65)  $ I-channel baseband buffer, biased to mid-rail
B_U_OP1_Q ADC_Q 0 V = 1.65 + 1.65 * tanh(1.0 * V(BB_U_OP1_D2) / 1.65)  $ Q-channel baseband buffer, biased to mid-rail
B_X_QWC1 LNA2_G 0 V = 0.707 * V(QWC_IN) * 1j  $ 90-degree hybrid coupler
RBLO LO GND 1Gig  $ DC bias: LO has no DC path
RBLO_SRC LO_SRC GND 1Gig  $ DC bias: LO_SRC has no DC path
RBQWC_IN QWC_IN GND 1Gig  $ DC bias: QWC_IN has no DC path
RBUSB_DN USB_DN GND 1Gig  $ DC bias: USB_DN has no DC path
RBUSB_DN_R USB_DN_R GND 1Gig  $ DC bias: USB_DN_R has no DC path
RBUSB_DP USB_DP GND 1Gig  $ DC bias: USB_DP has no DC path
RBUSB_DP_R USB_DP_R GND 1Gig  $ DC bias: USB_DP_R has no DC path
* ---- transient analysis ---------------------------------------------------
* Long enough to resolve the 50 kHz baseband beat that direct
* conversion produces from the 7.15 MHz tone against the LO.
*
* uic skips the DC operating point, which the LO oscillator cannot have: it is a
* relaxation oscillator, so every DC state it could rest in is unstable and
* ngspice's op solve fails with "timestep too small". Starting from the default
* all-zero state is both correct and sufficient -- C_LO_PER starts discharged,
* so the comparator starts high and the oscillator starts on its own.
.tran 20n 400u uic

.control
run
* wrdata, not print: `print` wraps its table at 80 columns and silently drops
* every vector past the fifth, which is how a dead Q channel hid behind a table
* that looked complete. wrdata writes every column it is given.
set wr_vecnames
wrdata sdr_trace.dat v(ADC_I) v(ADC_Q) v(ADC_I_D) v(ADC_Q_D)
+ v(MCU_LO) v(LO_SRC) v(LO) v(MIX_U_MIX1_LOQ)
+ v(MIX_U_MIX1_D) v(MIX_I1) v(MIX_Q1) v(BB_U_OP1_D1)
* Console summary only -- three vectors is what fits without truncation.
print v(ADC_I) v(ADC_Q) v(ADC_I_D)
.endc

.end
