* SDR direct-conversion receiver - generated by export_ngspice.py
* Source of truth: sim/scripts/sdr_skidl_circuit.py (60 parts)
*
* Active devices are behavioural macromodels: the common-gate LNAs and the
* zero-IF mixer have no standard SPICE primitive, and the baseband buffers are
* limiting voltage followers. The MCU is not simulated here -- it is the
* co-simulation partner (src/picsimlab_fmu).
*
* Node ADC_I / ADC_Q are the STM32 ADC inputs (PA0 / PA1).
.title SDR_Direct_Conversion_Receiver

* ---- 5 V supply -----------------------------------------------------------
V_VIN VIN_5V 0 DC 5.0

* ---- digital pin <-> analog node bridges ---------------------------------
* This is the co-simulation boundary. The STM32 is NOT simulated here; PicSimLab
* runs the firmware and drives these digital nodes. The bridges translate
* between the event-driven digital domain and ngspice's analog solver:
*
*   LO_SRC  digital  <- PicSimLab `pinsl` reading of PA6 (TIM3_CH1)
*     |  dac_bridge: digital 0/1 -> analog 0..3.3 V with a real slew rate
*   LO      analog   -> mixer LO port
*
*   ADC_I / ADC_Q analog -> digital, thresholded at in_low/in_high
*     |  adc_bridge
*   ADC_I_D / ADC_Q_D digital -> read back by the firmware for PA0 / PA1
*
* t_rise/t_fall give the output a finite edge instead of an ideal step, and
* input_load is a real capacitance loading the digital node. Both matter: a
* zero-rise-time source would let the analog solver take an unbounded timestep
* across every GPIO edge, and no load would let the digital node float.
* Port vectors need square brackets in both models, despite the ngspice manual
* showing them unbracketed (ngspice bug #146).
*
* Standalone (no PicSimLab attached) the digital nodes are held by weak bias
* resistors, so the deck still simulates and reports the chain's response to the
* RF input with the LO muted.
.model m_dac dac_bridge(out_low=0 out_high=3.3 out_undef=1.65
+                       input_load=5e-12 t_rise=20n t_fall=20n)
.model m_adc adc_bridge(in_low=1.0 in_high=2.3)

A_DAC_LO   [LO_SRC]        [LO]       m_dac
A_DAC_GAIN [GAIN_SRC]     [GAIN]     m_dac
A_ADC_I    [ADC_I]        [ADC_I_D]  m_adc
A_ADC_Q    [ADC_Q]        [ADC_Q_D]  m_adc

* Digital nodes need a DC reference for the event engine. 1 G is negligible
* against a real pin but keeps the matrix non-singular.
R_D_LO_SRC   LO_SRC   0 1Gig
R_D_GAIN_SRC GAIN_SRC 0 1Gig
R_D_ADC_I_D  ADC_I_D  0 1Gig
R_D_ADC_Q_D  ADC_Q_D  0 1Gig

* The STM32 timer pin is open-drain capable, so an unloaded digital node
* defaults to the logic-low level rather than an undefined 'U'.
V_LO_SRC   LO_SRC   0 DC 0
V_GAIN_SRC GAIN_SRC 0 DC 0

* ---- RF input -------------------------------------------------------------
* S11-based antenna networks from export_antenna_ngspice.py can be substituted
* here; this is a matched source standing in for a flat test signal.
V_ANT RF_IN 0 SIN(0 1m 7.15Meg 0 0)
R_TERM_SRC RF_IN GND 50

* Printed so a standalone run shows the boundary working: the digital side is
* readable, and so is the analog node the dac_bridge drives.
CC_AF_I ADC_I_F GND 100p
CC_AF_Q ADC_Q_F GND 100p
CC_ANA1 VCC_3V3_ANA GND 10u
CC_ANA2 VCC_3V3_ANA GND 100n
CC_BS1 LNA2_D FIL_IN 100p
CC_BS2 FIL_OUT GND 10p
CC_IN RF_IN LNA1_G 100p
CC_LDO1 VCC_3V3 GND 100u
CC_LDO2 VCC_3V3 GND 100n
CC_LNA1 LNA1_S GND 100p
CC_LO LO GND 100p
CC_MCU1 VCC_3V3 GND 100n
CC_MCU2 VCC_3V3 GND 100n
CC_MCU3 VCC_3V3 GND 4.7u
CC_MIX1 FIL_OUT MIX_IN_P 100p
CC_MIX2 GND MIX_IN_N 100p
CC_MIX3 VCC_MIX GND 100n
CC_OPI ADC_I GND 100p
CC_OPQ ADC_Q GND 100p
CC_OSC1 OSC_IN GND 22p
CC_OSC2 OSC_OUT GND 22p
CC_QWC LNA1_D QWC_IN 100p
RFB1 VCC_3V3 VCC_3V3_ANA 600
RL_BS1 FIL_IN FIL_OUT 8  $ 100u RF choke, modelled as winding resistance
RL_LNA1 VCC_3V3 LNA1_D 4  $ 18u RF choke, modelled as winding resistance
RL_LNA2 VCC_3V3_ANA LNA2_D 4  $ 18u RF choke, modelled as winding resistance
RL_MIX VCC_3V3_ANA VCC_MIX 60  $ 600R@100MHz RF choke, modelled as winding resistance
R_Q_LNA1_DRAIN LNA1_D VCC_3V3 2200  $ drain bias load
R_Q_LNA2_DRAIN LNA2_D VCC_3V3 2200  $ drain bias load
RR_AF_I ADC_I ADC_I_F 10k
RR_AF_Q ADC_Q ADC_Q_F 10k
RR_BS FIL_OUT GND 1k
RR_G1 VCC_3V3 LNA1_G 10k
RR_G2 LNA1_G GND 10k
RR_G3 VCC_3V3 LNA2_G 4.7k
RR_G4 LNA2_G GND 2.2k
RR_LO LO_SRC LO 50
RR_OPI MIX_I1 MIX_I2 10k
RR_OPQ MIX_Q1 MIX_Q2 10k
RR_QWC QWC_CP GND 1k
RR_S1 LNA1_S GND 1k
RR_S2 LNA2_S GND 1k
RR_TERM RF_IN GND 50
RR_USB1 USB_DP USB_DP_R 22
RR_USB2 USB_DN USB_DN_R 22
R_U_OP1_R1 MIX_I1 BB_U_OP1_D1 10k
R_U_OP1_R2 MIX_I2 BB_U_OP1_D1 10k
R_U_OP1_R3 MIX_Q1 BB_U_OP1_D2 10k
R_U_OP1_R4 MIX_Q2 BB_U_OP1_D2 10k
R_X_QWC1_CP QWC_CP 0 1k  $ coupler centre port
R_Y1_B1 OSC_IN VCC_3V3_ANA 1Meg
R_Y1_B2 OSC_OUT VCC_3V3_ANA 1Meg
E_Q_LNA1 LNA1_D 0 LNA1_G 0 12  $ common-gate LNA stage
E_Q_LNA2 LNA2_D 0 LNA2_G 0 12  $ common-gate LNA stage
B_U_LDO VCC_3V3 0 V = 3.3*ternary_fcn(V(VIN_5V)>3.5, 1, 0)  $ 3V3 LDO
R_U_MIX1_BIASP MIX_IN_P 0 1Meg
R_U_MIX1_BIASN MIX_IN_N 0 1Meg
R_U_MIX1_DIFF MIX_IN_P MIX_U_MIX1_D 1
R_U_MIX1_DIFN MIX_IN_N MIX_U_MIX1_D 1
B_U_MIX1_I MIX_I1 0 V = 0.5 * V(MIX_U_MIX1_D) * V(LO)
B_U_MIX1_Q MIX_Q1 0 V = 0.5 * V(MIX_U_MIX1_D) * V(LO) * 0
R_U_MIX1_TMIX_I2 MIX_I2 MIX_I1 1
R_U_MIX1_TMIX_Q2 MIX_Q2 MIX_Q1 1
B_U_OP1_I ADC_I 0 V = 1.65 * tanh(1.0 * V(BB_U_OP1_D1) / 1.65)  $ I-channel baseband buffer
B_U_OP1_Q ADC_Q 0 V = 1.65 * tanh(1.0 * V(BB_U_OP1_D2) / 1.65)  $ Q-channel baseband buffer
B_X_QWC1 LNA2_G 0 V = 0.707 * V(QWC_IN) * 1j  $ 90-degree hybrid coupler
RBLO LO GND 1Gig  $ DC bias: LO has no DC path
RBLO_SRC LO_SRC GND 1Gig  $ DC bias: LO_SRC has no DC path
RBQWC_IN QWC_IN GND 1Gig  $ DC bias: QWC_IN has no DC path
RBUSB_DN USB_DN GND 1Gig  $ DC bias: USB_DN has no DC path
RBUSB_DN_R USB_DN_R GND 1Gig  $ DC bias: USB_DN_R has no DC path
RBUSB_DP USB_DP GND 1Gig  $ DC bias: USB_DP has no DC path
RBUSB_DP_R USB_DP_R GND 1Gig  $ DC bias: USB_DP_R has no DC path
* ---- transient analysis ---------------------------------------------------
.tran 1u 20u

.control
run
* Report both sides of the bridge: the analog nodes the mixer sees, and the
* digital nodes the STM32 firmware would sample.
print v(ADC_I) v(ADC_Q) v(ADC_I_D) v(ADC_Q_D) v(LO) v(LO_SRC)
.endc

.end
